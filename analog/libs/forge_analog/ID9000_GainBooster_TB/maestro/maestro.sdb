ADE simulation setup
Run mode: Single Run, Sweeps and Corners
Tests:
  forge_analog_ID9000_GainBooster_TB_1: forge_analog/ID9000_GainBooster_TB/schematic, simulator spectre
    Variables: vsns = 0.350 0.352 0.354 0.355 0.356 0.358 0.360; vref = 0.355
    Outputs: v("/OUT" ?result "dcOp"); Vout; A0_dB; UGB; Ph1
