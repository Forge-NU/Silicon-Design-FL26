ADE simulation setup
Run mode: Single Run, Sweeps and Corners
Tests:
  forge_analog_ID9000_GainBooster_TB_1: forge_analog/ID9000_GainBooster_TB/schematic, simulator spectre
    Outputs: v("/OUT" ?result "dcOp")
