ADE simulation setup
Test forge_analog_ID9000_GainBooster_TB_1: forge_analog/ID9000_GainBooster_TB/schematic, simulator spectre
  Models: /Users/Student/idekel/.local/share/forge-silicon/pdks/sky130_release_0.1.0/libs/sky130_fd_pr_main/../../models/sky130.lib.spice[tt]
  Variables: vref = 0.355; vsns = 0.350 0.352 0.354 0.355 0.356 0.358 0.360
  Temperature: 27
  Analysis dc: (saves the operating point)
  Analysis ac: start=0.01 stop=10G dec=20
  Output Vout = v("/net3" ?result "dcOp")
  Output A0_dB = value(dB20(VF("/net3")) 1)
  Output UGB = unityGainFreq(VF("/net3"))
  Output Ph1 = value(phase(VF("/net3")) 1)
  Signals: /net3
Run mode: Single Run, Sweeps and Corners
