ADE simulation setup
Test forge_analog_ID900_REVA_TB_1: forge_analog/ID900_REVA_TB/schematic, simulator spectre
  Models: /Users/Student/idekel/.local/share/forge-silicon/pdks/sky130_release_0.1.0/libs/sky130_fd_pr_main/../../models/sky130.lib.spice[tt]
  Temperature: 27
  Analysis dc: (saves the operating point)
