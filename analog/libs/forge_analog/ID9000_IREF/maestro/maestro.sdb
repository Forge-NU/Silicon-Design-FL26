ADE simulation setup
Run mode: Single Run, Sweeps and Corners
Tests:
  forge_analog_ID9000_IREF_1: forge_analog/ID9000_IREF/schematic, simulator spectre
