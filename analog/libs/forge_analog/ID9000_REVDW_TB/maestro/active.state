ADE simulation setup
Test forge_analog_ID9000_REVDW_TB_1: forge_analog/ID9000_REVDW_TB/schematic, simulator spectre
  Models: /Users/Student/idekel/.local/share/forge-silicon/pdks/sky130_release_0.1.0/libs/sky130_fd_pr_main/../../models/sky130.lib.spice[tt]
  Variables: vcm = 1.2; supply = 4; Cap = 8; res = 1.55k
  Temperature: 27
  Analysis dc: (saves the operating point)
  Output current = abs(i("/V1/PLUS" ?result "dcOp")) (unticked)
  Output Phase = phase(getData("loopGain" ?result "stb")) (unticked)
  Output GainDB = dB20(getData("loopGain" ?result "stb")) (unticked)
  Output PM = (phaseMargin(getData("loopGain" ?result "stb")) + 180) (unticked)
  Output UGBW = cross(dB20(getData("loopGain" ?result "stb")) 0 1 "falling") (unticked)
  Output PSSRDB = (- dB20(v("/VOUT" ?result "ac"))) (unticked)
  Output psrr_1k = value((- dB20(v("/VOUT" ?result "ac"))) 1000) (unticked)
  Output psrr_1M = value((- dB20(v("/VOUT" ?result "ac"))) 1000000.0) (unticked)
  Output psrr_worst = ymin((- dB20(v("/VOUT" ?result "ac")))) (unticked)
  Signals: /VOUT as VOUT, /V1/PLUS (terminal)
Run mode: Single Run, Sweeps and Corners
Corners (all switched off):
  C0: temperature=0
  C1: temperature=27
  C2: temperature=85
