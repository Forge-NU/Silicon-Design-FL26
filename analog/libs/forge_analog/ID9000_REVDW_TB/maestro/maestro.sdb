ADE simulation setup
Run mode: Single Run, Sweeps and Corners
Tests:
  forge_analog_ID9000_REVDW_TB_1: forge_analog/ID9000_REVDW_TB/schematic, simulator spectre
    Variables: vcm = 1.2; supply = 4; Cap = 8; res = 1.55k
    Outputs: current; "/"; Phase; GainDB; phaseMargin(getData("loopGain" ?result "stb")); PM; UGBW; PSSRDB; psrr_1k; psrr_1M; psrr_worst
Corners (all switched off):
  C0: temperature=0
  C1: temperature=27
  C2: temperature=85
