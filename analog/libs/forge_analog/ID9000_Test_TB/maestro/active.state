ADE simulation setup
Test forge_analog_ID9000_Test_TB_1: forge_analog/ID9000_Test_TB/schematic, simulator spectre
  Models: /Users/Student/idekel/.local/share/forge-silicon/pdks/sky130_release_0.1.0/libs/sky130_fd_pr_main/../../models/sky130.lib.spice[tt]
  Variables: supply = 2:.1:5
  Temperature: 27
  Analysis dc: (saves the operating point)
  Signals: /VOUT
Run mode: Single Run, Sweeps and Corners
