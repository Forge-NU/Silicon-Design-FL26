ADE simulation setup
Run mode: Single Run, Sweeps and Corners
Tests:
  forge_analog_ID9000_Test_TB_1: forge_analog/ID9000_Test_TB/schematic, simulator spectre
    Variables: supply = 2:.1:5
    Outputs: /VOUT
