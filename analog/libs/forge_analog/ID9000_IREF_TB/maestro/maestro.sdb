ADE simulation setup
Run mode: Single Run, Sweeps and Corners
Tests:
  forge_analog_ID9000_IREF_TB_1: forge_analog/ID9000_IREF_TB/schematic, simulator spectre
    Variables: supply = 0:.1:5
