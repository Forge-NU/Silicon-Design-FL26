ADE simulation setup
Test forge_analog_ID9000_IREF_TB_1: forge_analog/ID9000_IREF_TB/schematic, simulator spectre
  Models: /Users/Student/idekel/.local/share/forge-silicon/pdks/sky130_release_0.1.0/libs/sky130_fd_pr_main/../../models/sky130.lib.spice[tt]
  Variables: supply = 0:.1:5
  Temperature: 27
  Analysis dc: (saves the operating point)
  Signals: /I1/NM0/D (terminal)
Run mode: Single Run, Sweeps and Corners
