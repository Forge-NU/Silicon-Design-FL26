ADE simulation setup
Run mode: Single Run, Sweeps and Corners
Tests:
  forge_analog_ID9000_REVD_TB_1: forge_analog/ID9000_REVD_TB/schematic, simulator spectre
    Variables: supply = 2:.05:4.5; vcm = 1.2
