ADE simulation setup
Run mode: Single Run, Sweeps and Corners
Tests:
  Forge_Analog:inverter2_testbench:1: Forge_Analog/inverter2_testbench/schematic, simulator spectre
    Outputs: dcs_vout; dcs_vin; tran_vout; tran_vin
Global variables:
  Vin = 0
