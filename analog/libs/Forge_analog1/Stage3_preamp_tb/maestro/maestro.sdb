ADE simulation setup
Run mode: Single Run, Sweeps and Corners
Tests:
  Forge_analog1_Stage3_preamp_tb_1: Forge_analog1/Stage3_preamp_tb/schematic, simulator spectre
    Variables: VB_DC = 2.108; Vic = 0.80273
    Outputs: dB20(((VF("/VoA") - VF("/VoB")) / (VF("/Vip") - VF("/Vin")))); dB20((VF("/VoA") - VF("/VoB"))); 3dbBW; (value(dB20((VF("/VoA") - VF("/VoB"))) 1000) - 3)
