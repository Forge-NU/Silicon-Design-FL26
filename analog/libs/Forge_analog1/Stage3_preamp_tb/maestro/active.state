ADE simulation setup
Test Forge_analog1_Stage1_preamp_tb_1: Forge_analog1/Stage1_preamp_tb/schematic, simulator spectre
  Models: /Users/Grad/cgidwani/.local/share/forge-silicon/pdks/sky130_release_0.1.0/libs/sky130_fd_pr_main/../../models/sky130.lib.spice[tt]
  Variables: VB_DC = 2.108; Vic = 0.9
  Temperature: 27
  Analysis ac: start=1k stop=10G dec=50
  Analysis dc: (saves the operating point)
  Output dB20(((VF("/VoA") - VF("/VoB")) / (VF("/Vip") - VF("/Vin"))))
  Output dB20((VF("/VoA") - VF("/VoB")))
  Output 3dbBW = bandwidth((VF("/VoA") - VF("/VoB")) 3 "low")
  Output (value(dB20((VF("/VoA") - VF("/VoB"))) 1000) - 3)
  Signals: /VoA, /VoB
Test Forge_analog1_Stage2_preamp_tb_1: Forge_analog1/Stage3_preamp_tb/schematic, simulator spectre
  Models: /Users/Grad/cgidwani/.local/share/forge-silicon/pdks/sky130_release_0.1.0/libs/sky130_fd_pr_main/../../models/sky130.lib.spice[tt]
  Variables: VB_DC = 2.108; Vic = 0.80273
  Temperature: 27
  Analysis ac: start=1k stop=10G dec=50
  Analysis dc: (saves the operating point)
  Output dB20(((VF("/VoA") - VF("/VoB")) / (VF("/Vip") - VF("/Vin"))))
  Output dB20((VF("/VoA") - VF("/VoB")))
  Output 3dbBW = bandwidth((VF("/VoA") - VF("/VoB")) 3 "low")
  Output (value(dB20((VF("/VoA") - VF("/VoB"))) 1000) - 3)
  Signals: /VoA, /VoB
Test Forge_analog1_Stage3_preamp_tb_1: Forge_analog1/Stage3_preamp_tb/schematic, simulator spectre
  Models: /Users/Grad/cgidwani/.local/share/forge-silicon/pdks/sky130_release_0.1.0/libs/sky130_fd_pr_main/../../models/sky130.lib.spice[tt]
  Variables: VB_DC = 2.108; Vic = 0.80273
  Temperature: 27
  Analysis ac: start=1k stop=10G dec=50
  Analysis dc: (saves the operating point)
  Output dB20(((VF("/VoA") - VF("/VoB")) / (VF("/Vip") - VF("/Vin"))))
  Output dB20((VF("/VoA") - VF("/VoB")))
  Output 3dbBW = bandwidth((VF("/VoA") - VF("/VoB")) 3 "low")
  Output (value(dB20((VF("/VoA") - VF("/VoB"))) 1000) - 3)
  Signals: /VoA, /VoB
