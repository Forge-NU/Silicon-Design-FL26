ADE simulation setup
Run mode: Single Run, Sweeps and Corners
Tests:
  Forge_analog1_ThreeStage_preamp_tb_1: Forge_analog1/ThreeStage_preamp_tb/schematic, simulator spectre
    Variables: Vic = 0.9
    Outputs: Stage1_AC; Stage2_AC; Total_Gain_dB; Total_3dB_BW; Total_Gain_1k; S1_VoA_DC; S2_VoB_DC; S3_VoA_DC; S1_DCdifferror; S2_DCdifferror; S3_DCdifferror; S1_VoB_DC; S2_VoA_DC; S3_VoB_DC
