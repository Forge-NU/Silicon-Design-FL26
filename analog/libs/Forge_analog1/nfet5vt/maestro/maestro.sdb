ADE simulation setup
Run mode: Single Run, Sweeps and Corners
Tests:
  Forge_analog1_nfet5vt_1: Forge_analog1/nfet5vt/schematic, simulator spectre
    Variables: VGS = 1
    Outputs: Id; gmId; Idw; VGS_12; VGS_8; IdW_12; IdW_8
