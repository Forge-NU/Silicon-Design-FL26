ADE simulation setup
Test Forge_analog1_nfet5vt_1: Forge_analog1/nfet5vt/schematic, simulator spectre
  Models: /Users/Grad/cgidwani/.local/share/forge-silicon/pdks/sky130_release_0.1.0/libs/sky130_fd_pr_main/../../models/sky130.lib.spice[tt]
  Variables: VGS = 1
  Temperature: 27
  Analysis dc: sweep VGS start=0 stop=3.3 step=5m
  Output Id = abs(IS("/NM0/D"))
  Output gmId = (deriv(abs(IS("/NM0/D"))) / abs(IS("/NM0/D")))
  Output Idw = (abs(IS("/NM0/D")) / 1e-05)
  Output VGS_12 = cross((deriv(abs(IS("/NM0/D"))) / abs(IS("/NM0/D"))) 12 1 "falling")
  Output VGS_8 = cross((deriv(abs(IS("/NM0/D"))) / abs(IS("/NM0/D"))) 8 1 "falling")
  Output IdW_12 = value((abs(IS("/NM0/D")) / 1e-05) cross((deriv(abs(IS("/NM0/D"))) / abs(IS("/NM0/D"))) 12 1 "falling"))
  Output IdW_8 = value((abs(IS("/NM0/D")) / 1e-05) cross((deriv(abs(IS("/NM0/D"))) / abs(IS("/NM0/D"))) 8 1 "falling"))
  Signals: /NM0/D (terminal)
Test Forge_analog1_pfet5vt_1: Forge_analog1/pfet5vt/schematic, simulator spectre
  Models: /Users/Grad/cgidwani/.local/share/forge-silicon/pdks/sky130_release_0.1.0/libs/sky130_fd_pr_main/../../models/sky130.lib.spice[tt]
  Variables: VSG = 1
  Temperature: 27
  Analysis dc: sweep VSG start=0 stop=3.3 step=5m
  Output Id = abs(IS("/PM0/D"))
  Output gmId = (deriv(abs(IS("/PM0/D"))) / abs(IS("/PM0/D")))
  Output Idw = (abs(IS("/PM0/D")) / 1e-05)
  Output VSG_12 = cross((deriv(abs(IS("/PM0/D"))) / abs(IS("/PM0/D"))) 12 1 "falling")
  Output VSG_8 = cross((deriv(abs(IS("/PM0/D"))) / abs(IS("/PM0/D"))) 8 1 "falling")
  Output IdW_12 = value((abs(IS("/PM0/D")) / 1e-05) cross((deriv(abs(IS("/PM0/D"))) / abs(IS("/PM0/D"))) 12 1 "falling"))
  Output IdW_8 = value((abs(IS("/PM0/D")) / 1e-05) cross((deriv(abs(IS("/PM0/D"))) / abs(IS("/PM0/D"))) 8 1 "falling"))
  Signals: /PM0/D (terminal)
