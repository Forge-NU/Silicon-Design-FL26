ADE simulation setup
Run mode: Single Run, Sweeps and Corners
Tests:
  Forge_analog1_pfet5vt_1: Forge_analog1/pfet5vt/schematic, simulator spectre
    Variables: VSG = 1
    Outputs: Id; gmId; Idw; VSG_12; VSG_8; IdW_12; IdW_8
