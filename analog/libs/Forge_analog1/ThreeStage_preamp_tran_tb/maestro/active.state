ADE simulation setup
Test Forge_analog1_ThreeStage_preamp_tb_1: Forge_analog1/ThreeStage_preamp_tb/schematic, simulator spectre
  Models: /Users/Grad/cgidwani/.local/share/forge-silicon/pdks/sky130_release_0.1.0/libs/sky130_fd_pr_main/../../models/sky130.lib.spice[tt]
  Variables: Vic = 0.9
  Temperature: 27
  Analysis ac: start=1k stop=10G dec=50
  Analysis dc: (saves the operating point)
  Output Stage1_AC = dB20((VF("/VoA") - VF("/VoB")))
  Output Stage2_AC = dB20((VF("/VoA2") - VF("/VoB2")))
  Output Total_Gain_dB = dB20((VF("/VoA3") - VF("/VoB3")))
  Output Total_3dB_BW = bandwidth((VF("/VoA3") - VF("/VoB3")) 3 "low")
  Output Total_Gain_1k = value(dB20((VF("/VoA3") - VF("/VoB3"))) 1000)
  Output S1_VoA_DC = VDC("/VoA")
  Output S1_VoB_DC = VDC("/VoB")
  Output S2_VoA_DC = VDC("/VoA2")
  Output S2_VoB_DC = VDC("/VoB2")
  Output S3_VoA_DC = VDC("/VoA3")
  Output S3_VoB_DC = VDC("/VoB3")
  Output S1_DCdifferror = (VDC("/VoA") - VDC("/VoB"))
  Output S2_DCdifferror = (VDC("/VoA2") - VDC("/VoB2"))
  Output S3_DCdifferror = (VDC("/VoA3") - VDC("/VoB3"))
  Signals: /VoA, /VoB, /VoA2, /VoB2, /VoA3, /VoB3
Test Forge_analog1_ThreeStage_preamp_tran_tb: Forge_analog1/ThreeStage_preamp_tran_tb/schematic, simulator spectre
  Models: /Users/Grad/cgidwani/.local/share/forge-silicon/pdks/sky130_release_0.1.0/libs/sky130_fd_pr_main/../../models/sky130.lib.spice[tt]
  Variables: Vic = 0.9; Vstep = 586u
  Temperature: 27
  Analysis tran: stop=40n maxstep=20p
  Analysis dc: (saves the operating point)
  Output Stage1_AC = dB20((VF("/VoA") - VF("/VoB")))
  Output Stage2_AC = dB20((VF("/VoA2") - VF("/VoB2")))
  Output Total_Gain_dB = dB20((VF("/VoA3") - VF("/VoB3")))
  Output Total_3dB_BW = bandwidth((VF("/VoA3") - VF("/VoB3")) 3 "low")
  Output Total_Gain_1k = value(dB20((VF("/VoA3") - VF("/VoB3"))) 1000)
  Output S1_VoA_DC = VDC("/VoA")
  Output S1_VoB_DC = VDC("/VoB")
  Output S2_VoA_DC = VDC("/VoA2")
  Output S2_VoB_DC = VDC("/VoB2")
  Output S3_VoA_DC = VDC("/VoA3")
  Output S3_VoB_DC = VDC("/VoB3")
  Output S1_DCdifferror = (VDC("/VoA") - VDC("/VoB"))
  Output S2_DCdifferror = (VDC("/VoA2") - VDC("/VoB2"))
  Output S3_DCdifferror = (VDC("/VoA3") - VDC("/VoB3"))
  Output Stage1_Diff = (VT("/VoA") - VT("/VoB"))
  Output Input_Diff = (VT("/Vip") - VT("/Vin"))
  Output Stage2_Diff = (VT("/VoA2") - VT("/VoB2"))
  Output Final_Diff = (VT("/VoA3") - VT("/VoB3"))
  Output Final_Settling_1pct = (settlingTime(clip((VT("/VoA3") - VT("/VoB3")) 4e-09 2.4e-08) 4e-09 t 2e-08 t 1 nil "time") - 5e-09)
  Signals: /VoA, /VoB, /VoA2, /VoB2, /VoA3, /VoB3
