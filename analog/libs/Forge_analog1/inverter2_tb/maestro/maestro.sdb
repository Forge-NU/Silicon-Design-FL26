ADE simulation setup
Run mode: Single Run, Sweeps and Corners
Tests:
  Forge_analog1:inverter2_tb:1: Forge_analog1/inverter2_tb/schematic, simulator spectre
    Variables: VIN = 0
    Outputs: dcs_vout; dcs_vin; tran_vout; tran_vin; dc_gain
Global variables:
  VIN = 0
