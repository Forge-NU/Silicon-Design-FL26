ADE simulation setup
Test Forge_analog1:inverter2_tb:1: Forge_analog1/inverter2_tb/schematic, simulator spectre
  Models: /Users/Grad/cgidwani/.local/share/forge-silicon/pdks/sky130_release_0.1.0/libs/sky130_fd_pr_main/../../models/sky130.lib.spice[tt]
  Variables: VIN = 0
  Temperature: 27
  Analysis dc: sweep VIN start=0 stop=1.8 step=10m (saves the operating point)
  Analysis tran: stop=100n errpreset=conservative
  Output dcs_vout = VS("/OUT")
  Output dcs_vin = VS("/IN")
  Output tran_vout = VT("/OUT")
  Output tran_vin = VT("/IN")
  Output dc_gain = deriv(dcs_vout)
Run mode: Single Run, Sweeps and Corners
Global variables:
  VIN = 0
