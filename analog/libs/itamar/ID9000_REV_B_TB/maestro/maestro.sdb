ADE simulation setup
Run mode: Single Run, Sweeps and Corners
Tests:
  forge_analog_ID9000_REV_B_TB_1: forge_analog/ID9000_REV_B_TB/schematic, simulator spectre
