ADE simulation setup
Run mode: Single Run, Sweeps and Corners
Tests:
  forge_analog:ID900_REVA_TB:1: forge_analog/ID900_REVA_TB/schematic, simulator spectre
  forge_analog:ID900_REVA_TB:2 (off): forge_analog/ID900_REVA_TB/schematic, simulator spectre
Global variables:
  VDC = 0
