ADE simulation setup
Run mode: Single Run, Sweeps and Corners
Tests:
  forge_analog_ID900_REVA_TB_1: forge_analog/ID900_REVA_TB/schematic, simulator spectre
