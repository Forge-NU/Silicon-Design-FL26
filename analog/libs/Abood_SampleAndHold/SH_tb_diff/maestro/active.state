ADE simulation setup
Test Forge_Analog_SH_tb_1: Abood_SampleAndHold/SH_tb_diff/schematic, simulator spectre
  Models: /Users/Student/aabusaleh/.local/share/forge-silicon/pdks/sky130_release_0.1.0/libs/sky130_fd_pr_main/../../models/sky130.lib.spice[tt]
  Variables: fin = 1.09375k
  Temperature: 27
  Analysis tran: stop=6.6m
  Output Sig_dB = value(dB20(dft((VT("/voutp") - VT("/voutn")) 0.00015 0.00655 64 "Rectangular" 1 "default" 1.0)) VAR("fin"))
  Output HD2_dBc = (value(dB20(dft((VT("/voutp") - VT("/voutn")) 0.00015 0.00655 64 "Rectangular" 1 "default" 1.0)) abs(((2 * VAR("fin")) - (10000 * round(((2 * VAR("fin")) / 10000)))))) - value(dB20(dft((VT("/voutp") - VT("/voutn")) 0.00015 0.00655 64 "Rectangular" 1 "default" 1.0)) VAR("fin")))
  Output HD3_dBc = (value(dB20(dft((VT("/voutp") - VT("/voutn")) 0.00015 0.00655 64 "Rectangular" 1 "default" 1.0)) abs(((3 * VAR("fin")) - (10000 * round(((3 * VAR("fin")) / 10000)))))) - value(dB20(dft((VT("/voutp") - VT("/voutn")) 0.00015 0.00655 64 "Rectangular" 1 "default" 1.0)) VAR("fin")))
  Output vin_diff = (VT("/vinp") - VT("/vinn"))
  Output vout_diff = (VT("/voutp") - VT("/voutn"))
  Output Vgs_pos = value((VT("/I1/V_g") - VT("/vinp")) 0.000207)
  Output Vgs_neg = value((VT("/I0/V_g") - VT("/vinn")) 0.000207)
  Signals: /vinp, /vinn, /I1/V_g, /I0/V_g
Run mode: Single Run, Sweeps and Corners
Corners:
  model folders: /Users/Student/aabusaleh/.local/share/forge-silicon/pdks/sky130_release_0.1.0/libs/sky130_fd_pr_main/../../models
  ss_85: temperature=85; sky130.lib.spice[ss]
  sf_85: temperature=85; sky130.lib.spice[ss sf]
  ff_85: temperature=85; sky130.lib.spice[ff]
  fs_85: temperature=85; sky130.lib.spice[fs]
Setup values for test Forge_Analog_SH_tb_1: fin = 1.09375k 4.84375k
