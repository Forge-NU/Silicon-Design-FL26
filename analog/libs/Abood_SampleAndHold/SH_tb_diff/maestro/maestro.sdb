ADE simulation setup
Run mode: Single Run, Sweeps and Corners
Tests:
  Forge_Analog_SH_tb_1: Abood_SampleAndHold/SH_tb_diff/schematic, simulator spectre
    Variables: fin = 1.09375k 4.84375k
    Outputs: "/I0/V_g"; Sig_dB; HD2_dBc; HD3_dBc; vin_diff; vout_diff; Vgs_pos; Vgs_neg
Corners:
  model folders: /Users/Student/aabusaleh/.local/share/forge-silicon/pdks/sky130_release_0.1.0/libs/sky130_fd_pr_main/../../models
  ss_85: temperature=85; sky130.lib.spice[ss]
  sf_85: temperature=85; sky130.lib.spice[ss sf]
  ff_85: temperature=85; sky130.lib.spice[ff]
  fs_85: temperature=85; sky130.lib.spice[fs]
