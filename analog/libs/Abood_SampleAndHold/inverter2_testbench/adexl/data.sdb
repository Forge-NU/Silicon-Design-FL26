ADE simulation setup
Run mode: Single Run, Sweeps and Corners
Tests:
  Abood_SampleAndHold:inverter2_testbench:1: Abood_SampleAndHold/inverter2_testbench/schematic, simulator spectre
    Outputs: dcs_vout; dcs_vin; tran_vout; tran_vin
Global variables:
  Vin = 0
