ADE simulation setup
Test Forge_Analog_I_leakage_1: Abood_SampleAndHold/I_leakage/schematic, simulator spectre
  Models: /Users/Student/aabusaleh/.local/share/forge-silicon/pdks/sky130_release_0.1.0/libs/sky130_fd_pr_main/../../models/sky130.lib.spice[tt]
  Variables: len = 0.5u 1u 2u; vd = 3.3
  Temperature: 27
  Analysis dc: (saves the operating point)
  Output Ileak = abs(IDC("/V0/PLUS"))
  Signals: /V0/PLUS (terminal)
Run mode: Single Run, Sweeps and Corners
Corners:
  model folders: /Users/Student/aabusaleh/.local/share/forge-silicon/pdks/sky130_release_0.1.0/libs/sky130_fd_pr_main/../../models
  ff_85: temperature=85; sky130.lib.spice[ff]
  fs_85: temperature=85; sky130.lib.spice[fs]
