ADE simulation setup
Run mode: Single Run, Sweeps and Corners
Tests:
  Forge_Analog_I_leakage_1: Abood_SampleAndHold/I_leakage/schematic, simulator spectre
    Variables: vd = 3.3; len = 0.5u 1u 2u
    Outputs: Ileak
Corners:
  model folders: /Users/Student/aabusaleh/.local/share/forge-silicon/pdks/sky130_release_0.1.0/libs/sky130_fd_pr_main/../../models
  ff_85: temperature=85; sky130.lib.spice[ff]
  fs_85: temperature=85; sky130.lib.spice[fs]
