ADE simulation setup
Test Forge_Analog_Ron_tb_1: Abood_SampleAndHold/Ron_tb/schematic, simulator spectre
  Models: /Users/Student/aabusaleh/.local/share/forge-silicon/pdks/sky130_release_0.1.0/libs/sky130_fd_pr_main/../../models/sky130.lib.spice[tt]
  Variables: vin = 0
  Temperature: 27
  Analysis dc: sweep vin start=0 stop=1.8 step=10m (saves the operating point)
  Output Ron = (0.01 / abs(i("/V2/PLUS" ?result "dc")))
  Output Ron_worst = ymax((0.01 / abs(i("/V2/PLUS" ?result "dc"))))
  Signals: /V2/PLUS (terminal)
Run mode: Single Run, Sweeps and Corners
Corners:
  model folders: /Users/Student/aabusaleh/.local/share/forge-silicon/pdks/sky130_release_0.1.0/libs/sky130_fd_pr_main/../../models
  ss_85: temperature=85; sky130.lib.spice[ss]
  sf_85: temperature=85; sky130.lib.spice[sf]
