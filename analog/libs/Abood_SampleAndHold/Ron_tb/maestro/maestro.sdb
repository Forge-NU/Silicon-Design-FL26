ADE simulation setup
Run mode: Single Run, Sweeps and Corners
Tests:
  Forge_Analog_Ron_tb_1: Abood_SampleAndHold/Ron_tb/schematic, simulator spectre
    Variables: vin = 0
    Outputs: Ron; Ron_worst
Corners:
  model folders: /Users/Student/aabusaleh/.local/share/forge-silicon/pdks/sky130_release_0.1.0/libs/sky130_fd_pr_main/../../models
  ss_85: temperature=85; sky130.lib.spice[ss]
  sf_85: temperature=85; sky130.lib.spice[sf]
