ADE simulation setup
Run mode: Single Run, Sweeps and Corners
Tests:
  Forge_Analog_SH_tb_1: Abood_SampleAndHold/SH_tb/schematic, simulator spectre
    Outputs: Vgs_boost; Track_err; Inject; Droop; "/I0/V_g"; /I0/V_g; Sig_dB; HD2_dBc; HD3_dBc; Vgs_wave; (VT("/I0/V_g") - VT("/vin")); Vgs_track; Vgs_sag
Corners:
  model folders: /Users/Student/aabusaleh/.local/share/forge-silicon/pdks/sky130_release_0.1.0/libs/sky130_fd_pr_main/../../models
  ss_85: temperature=85; sky130.lib.spice[ss]
  sf_85: temperature=85; sky130.lib.spice[ss sf]
  ff_85: temperature=85; sky130.lib.spice[ff]
  fs_85: temperature=85; sky130.lib.spice[fs]
