ADE simulation setup
Test Forge_Analog_SH_tb_1: Abood_SampleAndHold/SH_tb/schematic, simulator spectre
  Models: /Users/Student/aabusaleh/.local/share/forge-silicon/pdks/sky130_release_0.1.0/libs/sky130_fd_pr_main/../../models/sky130.lib.spice[tt]
  Temperature: 27
  Analysis tran: stop=6.6m
  Output Vgs_boost = value((VT("/I0/V_g") - VT("/vin")) 0.000207)
  Output Track_err = value((VT("/vout") - VT("/vin")) 0.0002075)
  Output Inject = (value(VT("/vout") 0.000208) - value(VT("/vout") 0.0002075))
  Output Droop = (value(VT("/vout") 0.000299) - value(VT("/vout") 0.000208))
  Output Sig_dB = value(dB20(dft(VT("/vout") 0.00015 0.00655 64 "Rectangular" 1 "default" 1.0)) 4843.75)
  Output HD2_dBc = (value(dB20(dft(VT("/vout") 0.00015 0.00655 64 "Rectangular" 1 "default" 1.0)) 312.5) - value(dB20(dft(VT("/vout") 0.00015 0.00655 64 "Rectangular" 1 "default" 1.0)) 4843.75))
  Output HD3_dBc = (value(dB20(dft(VT("/vout") 0.00015 0.00655 64 "Rectangular" 1 "default" 1.0)) 4531.25) - value(dB20(dft(VT("/vout") 0.00015 0.00655 64 "Rectangular" 1 "default" 1.0)) 4843.75))
  Output Vgs_wave = (VT("/I0/V_g") - VT("/vin"))
  Output Vgs_track = clip((VT("/I0/V_g") - VT("/vin")) 0.0001995 0.0002085)
  Output Vgs_sag = clip((VT("/I0/V_g") - VT("/vin")) 0.0001995 0.0002085)
  Signals: /vin, /vout, /net2, /I0/V_g
Run mode: Single Run, Sweeps and Corners
Corners:
  model folders: /Users/Student/aabusaleh/.local/share/forge-silicon/pdks/sky130_release_0.1.0/libs/sky130_fd_pr_main/../../models
  ss_85: temperature=85; sky130.lib.spice[ss]
  sf_85: temperature=85; sky130.lib.spice[ss sf]
  ff_85: temperature=85; sky130.lib.spice[ff]
  fs_85: temperature=85; sky130.lib.spice[fs]
