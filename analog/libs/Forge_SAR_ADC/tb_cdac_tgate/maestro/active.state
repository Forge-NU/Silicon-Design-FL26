ADE simulation setup
Test Forge_SAR_ADC:tb_cdac_tgate:1: Forge_SAR_ADC/tb_cdac_tgate/schematic, simulator spectre
  Models: /Users/Student/mwuchen/.local/share/forge-silicon/pdks/sky130_release_0.1.0/libs/sky130_fd_pr_main/../../models/sky130.lib.spice[tt]
  Temperature: 27
  Analysis tran: stop=8u
  Signals: /net2, /net3, /net1, /net01
Run mode: Single Run, Sweeps and Corners
