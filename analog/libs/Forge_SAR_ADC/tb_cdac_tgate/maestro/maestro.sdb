ADE simulation setup
Run mode: Single Run, Sweeps and Corners
Tests:
  Forge_SAR_ADC:tb_cdac_tgate:1: Forge_SAR_ADC/tb_cdac_tgate/schematic, simulator spectre
