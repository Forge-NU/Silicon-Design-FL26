ADE simulation setup
Run mode: Single Run, Sweeps and Corners
Tests:
  Forge_SAR_ADC:tb_cdac_mismatch:1: Forge_SAR_ADC/tb_cdac_mismatch/schematic, simulator spectre
