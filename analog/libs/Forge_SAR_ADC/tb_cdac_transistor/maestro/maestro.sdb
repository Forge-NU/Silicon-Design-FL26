ADE simulation setup
Run mode: Single Run, Sweeps and Corners
Tests:
  Forge_SAR_ADC_tb_cdac_transistor_1: Forge_SAR_ADC/tb_cdac_transistor/schematic, simulator spectre
