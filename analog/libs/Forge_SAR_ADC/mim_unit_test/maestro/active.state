ADE simulation setup
Test Forge_SAR_ADC:mim_unit_test:1: Forge_SAR_ADC/mim_unit_test/schematic, simulator spectre
  Models: /Users/Student/mwuchen/.local/share/forge-silicon/pdks/sky130_release_0.1.0/libs/sky130_fd_pr_main/../../models/sky130.lib.spice[tt]
  Temperature: 27
  Analysis ac: start=1k stop=100M dec=20
  Signals: /V0/PLUS (terminal)
Run mode: Single Run, Sweeps and Corners
