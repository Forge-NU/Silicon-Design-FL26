ADE simulation setup
Run mode: Single Run, Sweeps and Corners
Tests:
  Forge_SAR_ADC:mim_unit_test:1: Forge_SAR_ADC/mim_unit_test/schematic, simulator spectre
