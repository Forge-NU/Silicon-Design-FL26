ADE simulation setup
Run mode: Single Run, Sweeps and Corners
Tests:
  Forge_SAR_ADC:cdac_6plus6_switched:1: Forge_SAR_ADC/cdac_6plus6_switched/schematic, simulator spectre
