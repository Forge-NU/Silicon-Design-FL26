ADE simulation setup
Test Forge_SAR_ADC:tb_transmission_gate:1: Forge_SAR_ADC/tb_transmission_gate/schematic, simulator spectre
  Models: /Users/Student/mwuchen/.local/share/forge-silicon/pdks/sky130_release_0.1.0/libs/sky130_fd_pr_main/../../models/sky130.lib.spice[tt]
  Temperature: 27
  Analysis tran: stop=10u
  Signals: /net1, /net4
Run mode: Single Run, Sweeps and Corners
