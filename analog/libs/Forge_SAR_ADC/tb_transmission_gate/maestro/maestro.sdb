ADE simulation setup
Run mode: Single Run, Sweeps and Corners
Tests:
  Forge_SAR_ADC:tb_transmission_gate:1: Forge_SAR_ADC/tb_transmission_gate/schematic, simulator spectre
