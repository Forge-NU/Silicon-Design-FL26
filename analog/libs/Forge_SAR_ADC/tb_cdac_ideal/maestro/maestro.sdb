ADE simulation setup
Run mode: Single Run, Sweeps and Corners
Tests:
  Forge_SAR_ADC:tb_cdac_ideal:1: Forge_SAR_ADC/tb_cdac_ideal/schematic, simulator spectre
