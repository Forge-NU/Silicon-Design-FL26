ADE simulation setup
Run mode: Single Run, Sweeps and Corners
Tests:
  Forge_SAR_ADC:tb_tg_switch:1: Forge_SAR_ADC/tb_tg_switch/schematic, simulator spectre
