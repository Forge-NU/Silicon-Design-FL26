ADE simulation setup
Test RON: Matt_Mux/tb_muxDiff2to1/schematic, simulator spectre
  Models: /Users/Grad/mmarsicano/.local/share/forge-silicon/pdks/sky130_release_0.1.0/models/sky130.lib.spice[tt]
  Variables: vd0 = 0; iron = 1u
  Temperature: 27
  Analysis dc: sweep vcm start=0 stop=1.8 step=10m (saves the operating point)
  Output Ron_p = ((VS("/in0p") - VS("/outp")) / VAR("iron"))
  Output Ron_n = ((VS("/in0n") - VS("/outn")) / VAR("iron"))
  Output Ron_max = ymax(((VS("/in0p") - VS("/outp")) / VAR("iron")))
  Output Ron_min = ymin(((VS("/in0p") - VS("/outp")) / VAR("iron")))
  Output Ileak_off = abs(IS("/V1P/PLUS"))
  Output Ileak_off_max = ymax(abs(IS("/V1P/PLUS")))
Test TRAN: Matt_Mux/tb_muxDiff2to1/schematic, simulator spectre
  Models: /Users/Grad/mmarsicano/.local/share/forge-silicon/pdks/sky130_release_0.1.0/models/sky130.lib.spice[tt]
  Temperature: 27
  Analysis tran: stop=tsw+tnov+ttrack+3u errpreset=conservative maxstep=5n
  Output vout_diff = (VT("/outp") - VT("/outn"))
  Output settle_err_LSB = ((value((VT("/outp") - VT("/outn")) (VAR("tsw") + VAR("tnov") + VAR("ttrack"))) - VAR("vd1")) / ((2 * VAR("vref")) / 4096))
  Output settle_err_abs_LSB = (abs((value((VT("/outp") - VT("/outn")) (VAR("tsw") + VAR("tnov") + VAR("ttrack"))) - VAR("vd1"))) / ((2 * VAR("vref")) / 4096))
  Output kick_diff_LSB = ((value((VT("/outp") - VT("/outn")) (VAR("tsw") + VAR("tnov") + VAR("ttrack") + 1e-06)) - value((VT("/outp") - VT("/outn")) (VAR("tsw") + VAR("tnov") + VAR("ttrack")))) / ((2 * VAR("vref")) / 4096))
  Output kick_cm_mV = (1000.0 * (value(((VT("/outp") + VT("/outn")) / 2) (VAR("tsw") + VAR("tnov") + VAR("ttrack") + 1e-06)) - value(((VT("/outp") + VT("/outn")) / 2) (VAR("tsw") + VAR("tnov") + VAR("ttrack")))))
  Signals: /en0 as en0, /en1 as en1
Test AC: Matt_Mux/tb_muxDiff2to1/schematic, simulator spectre
  Models: /Users/Grad/mmarsicano/.local/share/forge-silicon/pdks/sky130_release_0.1.0/models/sky130.lib.spice[tt]
  Variables: vd0 = 0; ac0 = 0.5
  Temperature: 27
  Analysis ac: start=1 stop=10G dec=20
  Output gain_diff = dB20((VF("/outp") - VF("/outn")))
  Output BW_3dB = bandwidth((VF("/outp") - VF("/outn")) 3 "low")
Test XTALK: Matt_Mux/tb_muxDiff2to1/schematic, simulator spectre
  Models: /Users/Grad/mmarsicano/.local/share/forge-silicon/pdks/sky130_release_0.1.0/models/sky130.lib.spice[tt]
  Variables: vd1 = 0; vd0 = 0; ac1 = 0.5
  Temperature: 27
  Analysis ac: start=1 stop=10G dec=20
  Output xtalk_diff = dB20((VF("/outp") - VF("/outn")))
  Output xtalk_1k_dB = value(dB20((VF("/outp") - VF("/outn"))) 1000)
  Output xtalk_1M_dB = value(dB20((VF("/outp") - VF("/outn"))) 1000000)
Run mode: Single Run, Sweeps and Corners
Global variables:
  vdd = 1.8
  vref = 1.8
  vcm = 0.9
  vd0 = 0.6
  vcm1 = 0.9
  vd1 = -0.6
  chold = 12.8p
  iron = 0
  ac0 = 0
  ac1 = 0
  tsw = 2u
  tnov = 10n
  trf = 1n
  ttrack = 7.7u
Corners:
  model folders: /Users/Grad/mmarsicano/.local/share/forge-silicon/pdks/sky130_release_0.1.0/models
  ss_60: temperature=60; sky130.lib.spice[ss]
  ff_60: temperature=60; sky130.lib.spice[ff]
  sf_27: temperature=27; sky130.lib.spice[sf]
  fs_27: temperature=27; sky130.lib.spice[fs]
  ff_85: temperature=85; sky130.lib.spice[ff]
Specs:
  RON / Ron_max: < 10k
  RON / Ileak_off_max: < 100p
  TRAN / settle_err_abs_LSB: < 0.5
  AC / BW_3dB: > 1M
  XTALK / xtalk_1k_dB: < -80
  XTALK / xtalk_1M_dB: < -40
