ADE simulation setup
Run mode: Single Run, Sweeps and Corners
Tests:
  RON: Matt_Mux/tb_muxDiff2to1/schematic, simulator spectre
    Variables: iron = 1u; vd0 = 0
  TRAN: Matt_Mux/tb_muxDiff2to1/schematic, simulator spectre
  AC: Matt_Mux/tb_muxDiff2to1/schematic, simulator spectre
    Variables: ac0 = 0.5; vd0 = 0
  XTALK: Matt_Mux/tb_muxDiff2to1/schematic, simulator spectre
    Variables: ac1 = 0.5; vd0 = 0; vd1 = 0
Global variables:
  vdd = 1.8
  vref = 1.8
  vcm = 0.9
  vd0 = 0.6
  vcm1 = 0.9
  vd1 = -0.6
  chold = 12.8p
  iron = 0
  ac0 = 0
  ac1 = 0
  tsw = 2u
  tnov = 10n
  trf = 1n
  ttrack = 7.7u
Corners:
  model folders: /Users/Grad/mmarsicano/.local/share/forge-silicon/pdks/sky130_release_0.1.0/models
  ss_60: temperature=60; sky130.lib.spice[ss]
  ff_60: temperature=60; sky130.lib.spice[ff]
  sf_27: temperature=27; sky130.lib.spice[sf]
  fs_27: temperature=27; sky130.lib.spice[fs]
  ff_85: temperature=85; sky130.lib.spice[ff]
Specs:
  RON / Ron_max: < 10k
  RON / Ileak_off_max: < 100p
  TRAN / settle_err_abs_LSB: < 0.5
  AC / BW_3dB: > 1M
  XTALK / xtalk_1k_dB: < -80
  XTALK / xtalk_1M_dB: < -40
