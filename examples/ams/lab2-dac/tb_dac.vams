// Digital half of Lab 2: the unmodified examples/counter/counter4.v drives a
// transistor-level DAC through a 4-bit bus. The checker samples the analog
// output each cycle and compares it with VDD*count/16.
`include "disciplines.vams"
`timescale 1ns/1ps

module tb_dac;
  parameter real VDD_V = 1.8;
  parameter real TOL_V = VDD_V / 32.0;   // half an LSB

  reg clk = 1'b0, rst_n = 1'b0, en = 1'b0;
  wire [3:0] count;
  electrical vdd, vss, vout;
  ground vss;
  real vout_v, expected_v, err_v, max_err_v = 0.0;   // reals show up in SimVision
  integer checks = 0, errors = 0;

  vsource #(.type("dc"), .dc(VDD_V)) VDD (vdd, vss);

  counter4 U_CNT (.clk(clk), .rst_n(rst_n), .en(en), .count(count));
  dac4     XDAC  (.d(count), .vout(vout), .vdd(vdd), .vss(vss));

  always #10 clk = ~clk;                 // 50 MHz

  // Sample mid-cycle, after the DAC has settled from the last rising edge.
  always @(negedge clk) if (rst_n) begin
    vout_v     = $cds_get_analog_value("tb_dac.vout");
    expected_v = VDD_V * count / 16.0;
    err_v      = vout_v - expected_v;
    if (err_v < 0) err_v = -err_v;
    if (err_v > max_err_v) max_err_v = err_v;
    checks = checks + 1;
    if (err_v > TOL_V) errors = errors + 1;
    $display("%t: count=%2d vout=%0.4f V expected=%0.4f V err=%0.1f mV%s",
             $realtime, count, vout_v, expected_v, err_v * 1000.0,
             (err_v > TOL_V) ? "  <-- FAIL" : "");
  end

  initial begin
    $timeformat(-9, 1, " ns", 9);
    #25 rst_n = 1'b1; en = 1'b1;          // release reset, start counting
    repeat (20) @(posedge clk);           // 0..15 then wraps to 0..3
    #15;
    if (errors == 0)
      $display("FORGE_AMS_DAC_PASS checks=%0d max_err=%0.1f mV", checks, max_err_v * 1000.0);
    else
      $display("FORGE_AMS_DAC_FAIL errors=%0d of %0d checks", errors, checks);
    $finish;
  end
endmodule
